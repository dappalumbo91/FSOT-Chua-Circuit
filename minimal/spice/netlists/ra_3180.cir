* FSOT minimal chaotic circuit: x''' = -A x'' - x' + |x| - 1, A = R/RA (R = 1.8k, C = 100n, tau0 = 180us)
.include models/vendor/ti_sloj070/TL082.301
.model D1N4148 D(Is=2.52n Rs=0.568 N=1.752 Cjo=4p M=0.4 tt=20n BV=100)
Vcc vcc 0 9
Vee vee 0 -9
* U1: summing integrator (out o1 = tau0^2 x'')
RA o1 n1 3180
Rw o4 n1 1.8k
Rx o3 n1 1.8k
Rc vcc n1 40.2k
C1 n1 o1 100n
XUo1 0 n1 vcc vee o1 TL082
* U2: integrator (out o2 = -tau0 x')
R2 o1 n2 1.8k
C2 n2 o2 100n
XUo2 0 n2 vcc vee o2 TL082
* U3: integrator (out o3 = x)
R3 o2 n3 1.8k
C3 n3 o3 100n
XUo3 0 n3 vcc vee o3 TL082
* U4: inverting summer with the single nonlinearity (1N4148 half-wave): o4 = -(o2 + 2 max(x - Vd, 0))
R4 o2 n4 1.8k
Rf o4 n4 1.8k
D1 o3 dn D1N4148
Rd dn n4 900
XUo4 0 n4 vcc vee o4 TL082
.ic v(o3)=-0.5 v(o2)=0 v(o1)=0 v(n1)=0 v(n2)=0 v(n3)=0
.options method=gear reltol=1e-5 abstol=1e-10 vntol=1e-7
.tran 2u 0.6 0 2u uic
.control
run
wrdata out/ra_3180.dat v(o3) v(o2) v(o1)
quit
.endc
.end
