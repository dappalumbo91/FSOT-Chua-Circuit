* single_ua741_k10: nodes=1 Rc=None k=10 r0=0.0 opamp=ua741 rails=+/-9.6614
.include models/chua_node.lib
.include models/vendor/ua741.mod
.subckt OPA inp inn vcc vee out
X inp inn vcc vee out UA741
.ends OPA
Vcc vcc 0 9.6614
Vee vee 0 -9.6614
Xa a1 a2 vcc vee CHUA_NODE k=10 r0=0
.ic v(a1)=0.1 v(a2)=0
.options method=gear reltol=1e-4 abstol=1e-10 vntol=1e-7 itl4=100
.tran 1.8e-05 0.9 0 3.6e-06 uic
.control
set filetype=ascii
run
linearize v(a1) v(a2)
set wr_singlescale
set wr_vecnames
wrdata out/single_ua741_k10.dat v(a1) v(a2)
quit
.endc
.end
